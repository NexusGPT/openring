* ring test 6: joystick and record lines, pressed and released, with the chip's internal pull-up
* generated by make_decks.py from design/ecad/ring-circuit-work/patched3/design/ecad/ring
.param rpu=13k
Vr18 n_VDD_1V8 0 1.8 ; VDD_1V8
* switches SW1 SW2 SW3 SW4 SW5: contact resistance 0.5 ohm closed (Alps SKTAAAE010 spec 6.1 (design/datasheets/slim_alps-skta-aaae010-orwin.txt line 70): contact resistance 500 mohm max), open circuit released
.model swc SW(Ron=0.5 Roff=1e12 Vt=0.5 Vh=0.1)
Vp_SW1 p_SW1 0 PWL(0 0 0.000999 0 0.001 1 0.002 1 0.002001 0)
SSW1 n_JOY_UP 0 p_SW1 0 swc
Rpu_SW1 n_VDD_1V8 n_JOY_UP {rpu} ; U1 pin H1 internal pull-up (value NOT FOUND in any file, swept)
Vp_SW2 p_SW2 0 PWL(0 0 0.002999 0 0.003 1 0.004 1 0.004001 0)
SSW2 n_BTN_REC 0 p_SW2 0 swc
Rpu_SW2 n_VDD_1V8 n_BTN_REC {rpu} ; U1 pin H2 internal pull-up (value NOT FOUND in any file, swept)
Vp_SW3 p_SW3 0 PWL(0 0 0.004999 0 0.005 1 0.006 1 0.006001 0)
SSW3 n_JOY_DOWN 0 p_SW3 0 swc
Rpu_SW3 n_VDD_1V8 n_JOY_DOWN {rpu} ; U1 pin G2 internal pull-up (value NOT FOUND in any file, swept)
Vp_SW4 p_SW4 0 PWL(0 0 0.006999 0 0.007 1 0.008 1 0.008001 0)
SSW4 n_JOY_LEFT 0 p_SW4 0 swc
Rpu_SW4 n_VDD_1V8 n_JOY_LEFT {rpu} ; U1 pin G1 internal pull-up (value NOT FOUND in any file, swept)
Vp_SW5 p_SW5 0 PWL(0 0 0.008999 0 0.009 1 0.01 1 0.010001 0)
SSW5 n_JOY_RIGHT 0 p_SW5 0 swc
Rpu_SW5 n_VDD_1V8 n_JOY_RIGHT {rpu} ; U1 pin G10 internal pull-up (value NOT FOUND in any file, swept)
.options reltol=1e-4 abstol=1e-12 vntol=1e-7 ; tmax below sets the time resolution; results were checked for convergence (sim-notes.md)
.tran 1u 0.011 0 2u uic
.control
run
meas tran pr_SW1 find v(n_JOY_UP) at=0.0018
meas tran rl_SW1 find v(n_JOY_UP) at=0.0028
meas tran ip_SW1 find i(Vr18) at=0.0018
meas tran pr_SW2 find v(n_BTN_REC) at=0.0038
meas tran rl_SW2 find v(n_BTN_REC) at=0.0048
meas tran ip_SW2 find i(Vr18) at=0.0038
meas tran pr_SW3 find v(n_JOY_DOWN) at=0.0058
meas tran rl_SW3 find v(n_JOY_DOWN) at=0.0068
meas tran ip_SW3 find i(Vr18) at=0.0058
meas tran pr_SW4 find v(n_JOY_LEFT) at=0.0078
meas tran rl_SW4 find v(n_JOY_LEFT) at=0.0088
meas tran ip_SW4 find i(Vr18) at=0.0078
meas tran pr_SW5 find v(n_JOY_RIGHT) at=0.0098
meas tran rl_SW5 find v(n_JOY_RIGHT) at=0.0108
meas tran ip_SW5 find i(Vr18) at=0.0098
let pressed_max = max(pr_SW1, max(pr_SW2, max(pr_SW3, max(pr_SW4, pr_SW5))))
let released_min = min(rl_SW1, min(rl_SW2, min(rl_SW3, min(rl_SW4, rl_SW5))))
let ipress = max(abs(ip_SW1), max(abs(ip_SW2), max(abs(ip_SW3), max(abs(ip_SW4), abs(ip_SW5)))))
let ipress_min = min(abs(ip_SW1), min(abs(ip_SW2), min(abs(ip_SW3), min(abs(ip_SW4), abs(ip_SW5)))))
echo RESULT joy.pressed_max = $&pressed_max
echo RESULT joy.released_min = $&released_min
echo RESULT joy.pressed_current_max = $&ipress
echo RESULT joy.pressed_current_min = $&ipress_min
echo RESULT joy.nswitches = 5
wrdata @WAVE@ v(n_JOY_UP) v(n_BTN_REC) v(n_JOY_DOWN) v(n_JOY_LEFT) v(n_JOY_RIGHT)
quit
.endc
.end
* included: SW1 SW2 SW3 SW4 SW5
* excluded:
