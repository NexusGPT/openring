* case test 3: BQ25895 TS pin window with RT1, RT2 and the thermistor TH1 swept
* generated by make_decks.py from design/ecad/case
CC8 n_REGN 0 4.7e-06 ; 4.7uF 10V
RRT1 n_REGN n_TS 5230 ; 5.23k
RRT2 n_TS 0 30100 ; 30.1k
Vregn n_REGN 0 5 ; REGN, any value: the thresholds are ratios of REGN (p9)
Vrs rsw 0 DC 10000
* TH1 (10k 103AT in parts.csv) replaced by a resistor of the value on node rsw, swept in ohm
Bth n_TS 0 I = v(n_TS) / max(v(rsw), 1)
.dc Vrs 1000 60000 10
.control
run
meas dc rcold when v(n_TS)=3.6625 cross=1
meas dc rhot when v(n_TS)=2.2375 cross=1
meas dc rhtf when v(n_TS)=2.4125 cross=1
meas dc vts25 find v(n_TS) when v(rsw)=10000
let vts25r = vts25 / 5
echo RESULT ts.cold_edge_rth = $&rcold
echo RESULT ts.hot_edge_rth = $&rhot
echo RESULT ts.htf_edge_rth = $&rhtf
echo RESULT ts.vts_25c = $&vts25r
quit
.endc
.end
* included: C8 RT1 RT2 TH1
* excluded: C9(net outside this test: 3V3) C10(net outside this test: 3V3) R23(net outside this test: 3V3,EN) C30(net outside this test: EN) R22(net outside this test: 3V3,BOOT) R14(net outside this test: 3V3,I2C_SDA) R15(net outside this test: 3V3,I2C_SCL) R16(net outside this test: 3V3,CHG_INT_N) R17(net outside this test: 3V3,VRING_FAULT_N) R21(net outside this test: 3V3,CHG_CE_N) R25(net outside this test: VRING_EN) R8(net outside this test: LED_KR,LED_R) R9(net outside this test: LED_G,LED_KG) R10(net outside this test: LED_B,LED_KB) C1(net outside this test: VBUS_IN) C2(net outside this test: PMID) C3(net outside this test: PMID) C4(net outside this test: SYS) C5(net outside this test: SYS) C6(net outside this test: BAT) C7(net outside this test: BTST,SW) L1(net outside this test: SW,SYS) R11(net outside this test: ILIM) TH1(skipped by the test) R24(net outside this test: 3V3,CHG_STAT) R28(net outside this test: 3V3,CHG_DSEL) R27(net outside this test: CHG_OTG) L2(net outside this test: U3_L1,U3_L2) R3(net outside this test: 3V3,FB) R4(net outside this test: FB) C11(net outside this test: SYS) C12(net outside this test: 3V3) R1(net outside this test: CC1) R2(net outside this test: CC2) R6(net outside this test: CC1,CC1_SENSE) R7(net outside this test: CC2,CC2_SENSE) R5(net outside this test: U5_ILIM) C16(net outside this test: PMID) C15(net outside this test: VRING) R12(net outside this test: VRING,VRING_SENSE) R13(net outside this test: VRING_SENSE) R26(net outside this test: SD_CLK,SD_CLK_U4) R18(net outside this test: 3V3,SD_CMD) R19(net outside this test: 3V3,SD_D0) R20(net outside this test: 3V3,SD_D1) R29(net outside this test: 3V3,SD_D2) R30(net outside this test: 3V3,SD_D3) C13(net outside this test: 3V3) C14(net outside this test: 3V3)
