* ring test 5: level shifter U10 and the storage lines with the netlist pull-ups
* generated by make_decks.py from design/ecad/ring-circuit-work/patched3/design/ecad/ring
.include "design/sim/circuit/models/sn74axc4t774.lib"
.include "design/sim/circuit/models/csnp32gcr01.lib"
* rails are ideal sources here: the test is about the logic levels. VDD_1V8 = 1.8 V (VSET1 47 kohm, nPM1304 p43), VDD_SD = LDSW2 output from VDD_3V0 = 3.0 V (VSET2 150 kohm, p43)
Vr18 n_VDD_1V8 0 1.8
Vrsd n_VDD_SD 0 PWL(0 3.0 3.5m 3.0 3.5001m 0 3.9m 0) ; at 3.5 ms VDD_SD is switched off for the isolation phase
CC4 n_VDD_1V8 0 1e-05 ; 10uF
CC5 n_VDD_1V8 0 1e-07 ; 100nF
CC1 n_VDD_1V8 0 1e-07 ; 100nF
CC2 n_VDD_1V8 0 1e-07 ; 100nF
CC87 n_VDD_SD 0 1e-06 ; 1.0uF
CC78 n_VDD_1V8 0 1e-05 ; 10uF
CC80 n_VDD_1V8 0 1e-07 ; 100nF
CC81 n_VDD_1V8 0 1e-07 ; 100nF
CC82 n_VDD_SD 0 1e-07 ; 100nF
RR60 n_SDC_MISO n_VDD_SD 47000 ; 47k
RR63 n_SD_DAT1 n_VDD_SD 47000 ; 47k
RR64 n_SD_DAT2 n_VDD_SD 47000 ; 47k
RR65 n_SDC_CS n_VDD_SD 47000 ; 47k
CC60 n_VDD_SD 0 2.2e-06 ; 2.2uF
CC61 n_VDD_SD 0 1e-07 ; 100nF
XU10 n_SD_SCK n_SD_MOSI n_SD_CS n_SD_MISO n_SDC_SCK n_SDC_MOSI n_SDC_CS n_SDC_MISO n_VDD_1V8 n_VDD_SD n_VDD_1V8 n_VDD_1V8 n_VDD_1V8 0 0 SN74AXC4T774
XU3 n_VDD_SD n_SD_DAT2 n_SDC_CS n_SDC_SCK n_SDC_MOSI n_SDC_MISO n_SD_DAT1 drv drven CSNP32GCR01
Va_A9 n_SD_SCK 0 PWL(0 1.8 0.999m 1.8 1m 0 1.999m 0 2m 1.8 3.999m 1.8) ; chip pin A9, 1.8 V logic
Va_B10 n_SD_MOSI 0 PWL(0 1.8 0.999m 1.8 1m 0 1.999m 0 2m 1.8 3.999m 1.8) ; chip pin B10, 1.8 V logic
Va_D9 n_SD_CS 0 PWL(0 1.8 0.999m 1.8 1m 0 1.999m 0 2m 1.8 3.999m 1.8) ; chip pin D9, 1.8 V logic
Vdrv drv 0 PWL(0 0 0.999m 0 1m 1 1.999m 1 2m 0)
Vdrven drven 0 PWL(0 1 1.999m 1 2m 0)
.options reltol=1e-4 abstol=1e-12 vntol=1e-7 ; tmax below sets the time resolution; results were checked for convergence (sim-notes.md)
.tran 1u 0.0039 0 2u uic
.control
run
meas tran ab_h_sck find v(n_SDC_SCK) at=0.0009
meas tran ab_h_mosi find v(n_SDC_MOSI) at=0.0009
meas tran ab_h_cs find v(n_SDC_CS) at=0.0009
meas tran ab_l_sck find v(n_SDC_SCK) at=0.0019
meas tran ab_l_mosi find v(n_SDC_MOSI) at=0.0019
meas tran ab_l_cs find v(n_SDC_CS) at=0.0019
meas tran ba_l_chip find v(n_SD_MISO) at=0.0009
meas tran ba_l_shift find v(n_SDC_MISO) at=0.0009
meas tran ba_h_chip find v(n_SD_MISO) at=0.0019
meas tran ba_h_shift find v(n_SDC_MISO) at=0.0019
meas tran idle_chip find v(n_SD_MISO) at=0.0029
meas tran idle_shift find v(n_SDC_MISO) at=0.0029
meas tran pu1 find v(n_SD_DAT1) at=0.0029
meas tran pu2 find v(n_SD_DAT2) at=0.0029
meas tran iso_sck find v(n_SDC_SCK) at=0.0038
meas tran iso_mosi find v(n_SDC_MOSI) at=0.0038
meas tran iso_cs find v(n_SDC_CS) at=0.0038
meas tran iso_miso find v(n_SDC_MISO) at=0.0038
let ab_high = min(ab_h_sck, min(ab_h_mosi, ab_h_cs))
let ab_low = max(ab_l_sck, max(ab_l_mosi, ab_l_cs))
let pullup = min(pu1, pu2)
let iso = max(iso_sck, max(iso_mosi, max(iso_cs, iso_miso)))
echo RESULT shifter.ab_high_at_card_min = $&ab_high
echo RESULT shifter.ab_low_at_card_max = $&ab_low
echo RESULT shifter.ba_high_at_chip_min = $&ba_h_chip
echo RESULT shifter.ba_low_at_chip_max = $&ba_l_chip
echo RESULT shifter.idle_high_at_chip_min = $&idle_chip
echo RESULT shifter.idle_high_at_shifter_min = $&idle_shift
echo RESULT shifter.pullup_high_at_card_min = $&pullup
echo RESULT shifter.vcc_isolation_leak_max = $&iso
echo RESULT shifter.card_low_at_shifter_max = $&ba_l_shift
echo RESULT shifter.card_high_at_shifter_min = $&ba_h_shift
wrdata @WAVE@ v(n_SDC_SCK) v(n_SDC_MISO) v(n_SD_MISO) v(n_SD_DAT1) v(n_SD_DAT2)
quit
.endc
.end
* included: C4 C5 C1 C2 C87 C78 C80 C81 C82 R60 R63 R64 R65 C60 C61 U10 U3
* excluded: L1(net outside this test: DCC,DECD) C6(net outside this test: DECD) FB1(net outside this test: DECA,DECD) C7(net outside this test: DECA) C14(net outside this test: DECA) C10(net outside this test: VDD_USB_3V3) R1(net outside this test: U1_VBUS,VBUS) C11(net outside this test: U1_VBUS) R2(net outside this test: TXRTUNE) L2(net outside this test: ANT1_NODE,ANT2_NODE) C3(net outside this test: ANT2_NODE) L3(net outside this test: ANT2_NODE,ANT3_NODE) C12(net outside this test: ANT3_NODE) L4(net outside this test: ANT3_NODE,RF_FEED) C13(DNP) LT1(net outside this test: ANT_TRIM) C89(DNP) C71(net outside this test: VBUS) C85(net outside this test: VBAT) C88(net outside this test: VSYS) C86(net outside this test: VDD_MIC) C72(net outside this test: VBUS) C73(net outside this test: VBUSOUT) C74(net outside this test: VSYS) C75(net outside this test: VSYS) C76(net outside this test: VSYS) C77(net outside this test: VSYS) L71(net outside this test: SW1) L72(net outside this test: SW2,VDD_3V0) C79(net outside this test: VDD_3V0) C90(net outside this test: VDD_3V0) R71(net outside this test: VSET1) R72(net outside this test: VSET2) R73(net outside this test: VBUS) RT1(net outside this test: NTC) R57(net outside this test: PMIC_SDA) R58(net outside this test: PMIC_SCL) R31(net outside this test: MIC1_DATA,MIC_A_DATA) C31(net outside this test: VDD_MIC) C35(net outside this test: VDD_MIC) R32(net outside this test: MIC2_DATA,MIC_A_DATA) C32(net outside this test: VDD_MIC) C36(net outside this test: VDD_MIC) L10(net outside this test: SGM_SW1,SGM_SW2) C21(net outside this test: VBAT) C22(net outside this test: SGM_AVIN) C23(net outside this test: SGM_C1N,SGM_C1P) C24(net outside this test: SGM_VOUT) C25(net outside this test: ELVDD) C26(net outside this test: SGM_AVDD) C27(net outside this test: SGM_VON) C28(net outside this test: ELVSS) C29(net outside this test: ELVSS) R66(net outside this test: OLED_PWR_EN) C83(net outside this test: VBAT) C84(net outside this test: VMOT) R61(net outside this test: MOTOR,MOT_EN) R62(net outside this test: MOT_EN)
