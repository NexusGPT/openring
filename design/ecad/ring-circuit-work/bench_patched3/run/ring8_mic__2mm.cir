* ring test 8: supply ripple at a microphone Vdd pin, pulsed microphone current
* generated by make_decks.py from design/ecad/ring-circuit-work/patched3/design/ecad/ring
.param lmm=2
* track from the 1 uF part C31 to the Vdd pin: 0.5 nH per mm (lead's figure), copper 0.10 mm x 0.018 mm: 9.33 mohm per mm (resistivity 1.68e-8 ohm m, standard value)
V18 rail 0 1.8 ; ideal 1.8 V behind the load switch
Rsw rail nout 0.2 ; LDSW1 RDSONLS 200 mohm, nPM1304 p69
Cc86 nout 0 1e-06 ; C86 1.0uF
Cc31 nout 0 1e-06 ; C31 1uF
Ltrk nout nmid {0.5n*lmm}
Rtrk nmid pin {0.00933*lmm}
Cc35 pin 0 1e-09 ; C35 1nF C0G at the pin
Imic pin 0 PULSE(0 1.42m 0 1n 1n 325.5n 651n) ; 2 x 710 uA square at 1.536 MHz (period 651 ns), Knowles sheet
.options reltol=1e-4 abstol=1e-12 vntol=1e-7
.tran 1n 40u 0 5n uic
.control
run
meas tran vmax max v(pin) from=30u to=40u
meas tran vmin min v(pin) from=30u to=40u
let pp = vmax - vmin
echo RESULT mic.pp = $&pp
quit
.endc
.end
* included: C86 C31 C35 U5
* excluded:
