* case test 2: BQ25895 charge settings at power-on (CE held low by R21) from the register defaults and the ILIM resistor
* generated by make_decks.py from design/ecad/case
* defaults of the BQ25895 registers, each with its page in pass-lines.md section B: ICHG 2.048 A (p36), VREG 4.208 V (p38), IINLIM 0.5 A (p32), KILIM 320 / 355 / 390 (p9)
.param ichg_reg=2.048
.param vreg=4.208
.param iinlim=0.5
.param rilim=260 ; R11 from parts.csv
.param eta=0.90 ; MODEL CHOICE, converter efficiency
.param psys=0.9 ; no other load, the largest charge current
* case cell at 3.7 V nominal with 60 mohm; VBUS 5 V from a USB source; input limit = min(register, ILIM pin KILIM/RILIM)
Vbus vbus 0 5
Vocv cell_i 0 3.7
Rcellx cell_i nbat 0.06
.param ilim_pin_min = {320/rilim}
.param iin = {min(iinlim, ilim_pin_min)}
* charge current from the input power: (eta * 5 V * iin - psys) / Vbat, clamped by the register ICHG and by the CV limit
Bchg2 0 nbat I = min(ichg_reg, min(max((eta*5*iin - psys)/max(v(nbat),2.5), 0), max((vreg - v(nbat))*1000, 0)))
* the register values and the pin limit are carried on nodes so that the control block can print them
Vn_ichg n_ichg 0 {ichg_reg}
Vn_vreg n_vreg 0 {vreg}
Vn_pin n_pin 0 {ilim_pin_min}
.options reltol=1e-4 abstol=1e-12 vntol=1e-7
.op
.control
run
let ichg_in = i(vocv)
echo RESULT charge.ichg_reg_default = $&v(n_ichg)
echo RESULT charge.vreg_default = $&v(n_vreg)
echo RESULT charge.ilim_pin_min = $&v(n_pin)
echo RESULT charge.icc_input_limited = $&ichg_in
quit
.endc
.end
* included: R11
* excluded:
