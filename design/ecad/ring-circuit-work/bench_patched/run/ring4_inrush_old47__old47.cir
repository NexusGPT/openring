* ring test 4: storage supply inrush when the power chip enables LDSW2
* generated by make_decks.py from design/ecad/ring-circuit-work/patched/design/ecad/ring
* override: C60 = 4.7uF
.include "design/sim/circuit/models/tlv755p30.lib"
.include "design/sim/circuit/models/npm1304.lib"
.include "design/sim/circuit/models/sn74axc4t774.lib"
.include "design/sim/circuit/models/csnp32gcr01.lib"
.param ocv=3.45
.param rcell=1.0
.param ss=0.05
.param ssdis=0
CC4 n_VDD_1V8 0 1e-05 ; 10uF
CC5 n_VDD_1V8 0 1e-07 ; 100nF
CC1 n_VDD_1V8 0 1e-07 ; 100nF
CC2 n_VDD_1V8 0 1e-07 ; 100nF
RR1 n_VBUS n_U1_VBUS 2.2 ; 2.2R
CC11 n_U1_VBUS 0 4.7e-06 ; 4.7uF
CC71 n_VBUS 0 1e-06 ; 1.0uF 25V
CC85 n_VBAT 0 2.2e-06 ; 2.2uF
CC88 n_VSYS 0 1e-05 ; 10uF
CC86 n_VDD_MIC 0 1e-06 ; 1.0uF
CC87 n_VDD_SD 0 1e-06 ; 1.0uF
CC72 n_VBUS 0 1e-07 ; 100nF
CC73 n_VBUSOUT 0 1e-06 ; 1.0uF
CC74 n_VSYS 0 1e-05 ; 10uF
CC75 n_VSYS 0 1e-05 ; 10uF
CC76 n_VSYS 0 1e-09 ; 1.0nF
CC77 n_VSYS 0 1e-09 ; 1.0nF
CC78 n_VDD_1V8 0 1e-05 ; 10uF
CC79 n_VDD_3V0 0 1e-05 ; 10uF
CC80 n_VDD_1V8 0 1e-07 ; 100nF
RR71 n_VSET1 0 47000 ; 47k
RR72 n_VSET2 0 150000 ; 150k
RR73 n_VBUS 0 330000 ; 330k
RRT1 n_NTC 0 10000 ; 10k NTC
CC31 n_VDD_MIC 0 1e-06 ; 1uF
CC35 n_VDD_MIC 0 1e-09 ; 1nF C0G
CC32 n_VDD_MIC 0 1e-06 ; 1uF
CC36 n_VDD_MIC 0 1e-09 ; 1nF C0G
CC81 n_VDD_1V8 0 1e-07 ; 100nF
CC82 n_VDD_SD 0 1e-07 ; 100nF
RR60 n_SDC_MISO n_VDD_SD 47000 ; 47k
RR63 n_SD_DAT1 n_VDD_SD 47000 ; 47k
RR64 n_SD_DAT2 n_VDD_SD 47000 ; 47k
RR65 n_SDC_CS n_VDD_SD 47000 ; 47k
CC60 n_VDD_SD 0 4.7e-06 ; 4.7uF
CC61 n_VDD_SD 0 1e-07 ; 100nF
CC21 n_VBAT 0 4.7e-06 ; 4.7uF
CC83 n_VBAT 0 1e-05 ; 10uF
CC84 n_VMOT 0 4.7e-06 ; 4.7uF
RR61 n_MOTOR n_MOT_EN 100 ; 100R
RR62 n_MOT_EN 0 100000 ; 100k
* BT1 cell: 4.35V 20-27mAh at US9 (17.6mAh min at US7) curved ; its capacity (read from parts.csv) is not used by a DC or short test; open-circuit voltage and series resistance are parameters
Vocv cell_i 0 PWL(0 0 100u {ocv})
Rcellx cell_i n_VBAT {rcell}
Vvbus n_VBUS 0 DC 0
Vls1 ls1en 0 0
Vls2 ls2en 0 PWL(0 0 10m 0 10.001m 1) ; host enables LDSW2 at 10 ms
Vchg chgen 0 0
XU2 n_VBUS n_VBUSOUT n_VSYS n_VBAT n_VDD_1V8 n_VDD_3V0 n_VDD_1V8 n_VDD_MIC n_VDD_3V0 n_VDD_SD n_VSET1 n_VSET2 ls1en ls2en chgen NPM1304 params: ss2={ss} ssdis2={ssdis}
XU11 n_VBAT n_VMOT n_MOT_EN 0 TLV755P30
Vmotor n_MOTOR 0 0
XU10 n_SD_SCK n_SD_MOSI n_SD_CS n_SD_MISO n_SDC_SCK n_SDC_MOSI n_SDC_CS n_SDC_MISO n_VDD_1V8 n_VDD_SD n_VDD_1V8 n_VDD_1V8 n_VDD_1V8 0 0 SN74AXC4T774
XU3 n_VDD_SD n_SD_DAT2 n_SDC_CS n_SDC_SCK n_SDC_MOSI n_SDC_MISO n_SD_DAT1 drv drven CSNP32GCR01
Va_A9 n_SD_SCK 0 0 ; chip pin A9 driven low (idle)
Va_B10 n_SD_MOSI 0 0 ; chip pin B10 driven low (idle)
Va_D9 n_SD_CS 0 0 ; chip pin D9 driven low (idle)
Vdrv drv 0 0
Vdrven drven 0 0
Bu1 n_VDD_1V8 0 I = 0.003 ; U1 supply load, architecture.md line 89: main chip 3.0 mA at 1.8 V, estimate
.options reltol=1e-4 abstol=1e-12 vntol=1e-7 ; tmax below sets the time resolution; results were checked for convergence (sim-notes.md)
.tran 1u 0.15 0 5u uic
.control
run
meas tran ils_peak min i(v.xu2.vsl2) from=0.0099 to=0.15
meas tran ils_peak_p max i(v.xu2.vsl2) from=0.0099 to=0.15
meas tran ibuck2_peak max i(v.xu2.vsn2) from=0.0099 to=0.15
meas tran v30_min min v(n_VDD_3V0) from=0.0099 to=0.15
meas tran vsd_final avg v(n_VDD_SD) from=0.13 to=0.15
meas tran t90_abs when v(n_VDD_SD)=2.7 rise=1
let t90 = t90_abs - 0.01
let ils_abs = max(abs(ils_peak), abs(ils_peak_p))
echo RESULT inrush.ils_abs = $&ils_abs
echo RESULT inrush.ibuck2_peak = $&ibuck2_peak
echo RESULT inrush.v30_min = $&v30_min
echo RESULT inrush.vsd_final = $&vsd_final
echo RESULT inrush.t90 = $&t90
wrdata design/ecad/ring-circuit-work/bench_patched/run/ring4_inrush_old47__old47.wave.txt v(n_VDD_3V0) v(n_VDD_SD) v(n_VBAT)
quit
.endc
.end
* included: C4 C5 C1 C2 R1 C11 C71 C85 C88 C86 C87 C72 C73 C74 C75 C76 C77 C78 C79 C80 R71 R72 R73 RT1 C31 C35 C32 C36 C81 C82 R60 R63 R64 R65 C60 C61 C21 C83 C84 R61 R62 BT1 U2 U11 U10 U3
* excluded: L1(net outside this test: DCC,DECD) C6(net outside this test: DECD) FB1(net outside this test: DECA,DECD) C7(net outside this test: DECA) C14(net outside this test: DECA) C10(net outside this test: VDD_USB_3V3) R2(net outside this test: TXRTUNE) L2(net outside this test: ANT1_NODE,ANT2_NODE) C3(net outside this test: ANT2_NODE) L3(net outside this test: ANT2_NODE,ANT3_NODE) C12(net outside this test: ANT3_NODE) L4(net outside this test: ANT3_NODE,RF_FEED) C13(DNP) LT1(net outside this test: ANT_TRIM) C89(DNP) L71(net outside this test: SW1) L72(net outside this test: SW2) R57(net outside this test: PMIC_SDA) R58(net outside this test: PMIC_SCL) R31(net outside this test: MIC1_DATA,MIC_A_DATA) R32(net outside this test: MIC2_DATA,MIC_A_DATA) L10(net outside this test: SGM_SW1,SGM_SW2) C22(net outside this test: SGM_AVIN) C23(net outside this test: SGM_C1N,SGM_C1P) C24(net outside this test: SGM_VOUT) C25(net outside this test: ELVDD) C26(net outside this test: SGM_AVDD) C27(net outside this test: SGM_VON) C28(net outside this test: ELVSS) C29(net outside this test: ELVSS) R66(net outside this test: OLED_PWR_EN)
