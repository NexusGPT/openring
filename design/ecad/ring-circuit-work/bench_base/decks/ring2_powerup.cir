* ring test 2: power-up order and levels from a cell
* generated by make_decks.py from design/ecad/ring-circuit-work/base/design/ecad/ring
.include "design/sim/circuit/models/tlv755p30.lib"
.include "design/sim/circuit/models/npm1304.lib"
.param ocv=3.3
.param rcell=1.0
CC4 n_VDD_1V8 0 1e-05 ; 10uF
CC5 n_VDD_1V8 0 1e-07 ; 100nF
CC1 n_VDD_1V8 0 1e-07 ; 100nF
CC2 n_VDD_1V8 0 1e-07 ; 100nF
RR1 n_VBUS n_U1_VBUS 2.2 ; 2.2R
CC11 n_U1_VBUS 0 4.7e-06 ; 4.7uF
CC71 n_VBUS 0 1e-06 ; 1.0uF 25V
CC85 n_VBAT 0 2.2e-06 ; 2.2uF
CC88 n_VSYS 0 1e-05 ; 10uF
CC86 n_VDD_MIC 0 1e-06 ; 1.0uF
CC87 n_VDD_SD 0 1e-06 ; 1.0uF
CC72 n_VBUS 0 1e-07 ; 100nF
CC73 n_VBUSOUT 0 1e-06 ; 1.0uF
CC74 n_VSYS 0 1e-05 ; 10uF
CC75 n_VSYS 0 1e-05 ; 10uF
CC76 n_VSYS 0 1e-09 ; 1.0nF
CC77 n_VSYS 0 1e-09 ; 1.0nF
CC78 n_VDD_1V8 0 1e-05 ; 10uF
CC79 n_VDD_3V0 0 1e-05 ; 10uF
CC80 n_VDD_1V8 0 1e-07 ; 100nF
RR71 n_VSET1 0 47000 ; 47k
RR72 n_VSET2 0 150000 ; 150k
RRT1 n_NTC 0 10000 ; 10k NTC
CC31 n_VDD_MIC 0 1e-06 ; 1uF
CC35 n_VDD_MIC 0 1e-09 ; 1nF C0G
CC32 n_VDD_MIC 0 1e-06 ; 1uF
CC36 n_VDD_MIC 0 1e-09 ; 1nF C0G
CC81 n_VDD_1V8 0 1e-07 ; 100nF
CC82 n_VDD_SD 0 1e-07 ; 100nF
CC60 n_VDD_SD 0 2.2e-06 ; 2.2uF
CC61 n_VDD_SD 0 1e-07 ; 100nF
CC21 n_VBAT 0 4.7e-06 ; 4.7uF
CC83 n_VBAT 0 1e-05 ; 10uF
CC84 n_VMOT 0 1e-05 ; 10uF
RR61 n_MOTOR n_MOT_EN 100 ; 100R
RR62 n_MOT_EN 0 100000 ; 100k
* BT1 cell: 4.35V 20-27mAh at US9 (17.6mAh min at US7) curved ; its capacity (read from parts.csv) is not used by a DC or short test; open-circuit voltage and series resistance are parameters
Vocv cell_i 0 PWL(0 0 100u {ocv})
Rcellx cell_i n_VBAT {rcell}
Vvbus n_VBUS 0 DC 0 ; no case present
Vls2 ls2en 0 PWL(0 0 0.02 0 0.020001 1) ; host turns on LDSW2 (storage) in BOOT, firmware.md 8.2
Vls1 ls1en 0 PWL(0 0 0.04 0 0.040001 1) ; host turns on LDSW1 (microphones) at the start of a recording
Vchg chgen 0 0
XU2 n_VBUS n_VBUSOUT n_VSYS n_VBAT n_VDD_1V8 n_VDD_3V0 n_VDD_1V8 n_VDD_MIC n_VDD_3V0 n_VDD_SD n_VSET1 n_VSET2 ls1en ls2en chgen NPM1304
XU11 n_VBAT n_VMOT n_MOT_EN 0 TLV755P30
Vmotor n_MOTOR 0 0 ; U1 pin MOTOR is low (the chip drives nothing yet)
Bm n_VMOT 0 I = v(n_VMOT) / 17.14 ; M1 at its stall resistance 3.0 V / 175 mA
Bu1 n_VDD_1V8 0 I = (time > 0.01) ? 0.003 : 0 ; U1 architecture.md line 89: main chip 3.0 mA at 1.8 V, estimate
.options reltol=1e-4 abstol=1e-12 vntol=1e-7 ; tmax below sets the time resolution; results were checked for convergence (sim-notes.md)
.tran 2u 0.08 0 5u uic
.control
run
meas tran t18 when v(n_VDD_1V8)=1.71 rise=1
meas tran t30 when v(n_VDD_3V0)=2.85 rise=1
meas tran tsd when v(n_VDD_SD)=2.7 rise=1
meas tran tmic when v(n_VDD_MIC)=1.6 rise=1
meas tran v18_min min v(n_VDD_1V8) from=0.01 to=0.08
meas tran v18_peak max v(n_VDD_1V8) from=0 to=0.08
meas tran v30_min min v(n_VDD_3V0) from=0.01 to=0.08
meas tran v30_peak max v(n_VDD_3V0) from=0 to=0.08
meas tran vmot_peak max v(n_VMOT) from=0 to=0.08
meas tran vsd_pre_peak max v(n_VDD_SD) from=0 to=0.0199
meas tran vsd_min min v(n_VDD_SD) from=0.025 to=0.08
meas tran vsd_peak max v(n_VDD_SD) from=0 to=0.08
meas tran vmic_min min v(n_VDD_MIC) from=0.045 to=0.08
let order_sd = tsd - t30
echo RESULT powerup.t18 = $&t18
echo RESULT powerup.t30 = $&t30
echo RESULT powerup.tsd = $&tsd
echo RESULT powerup.tmic = $&tmic
echo RESULT powerup.v18_min = $&v18_min
echo RESULT powerup.v18_peak = $&v18_peak
echo RESULT powerup.v30_min = $&v30_min
echo RESULT powerup.v30_peak = $&v30_peak
echo RESULT powerup.vmot_peak = $&vmot_peak
echo RESULT powerup.vsd_pre_peak = $&vsd_pre_peak
echo RESULT powerup.vsd_min = $&vsd_min
echo RESULT powerup.vsd_peak = $&vsd_peak
echo RESULT powerup.vmic_min = $&vmic_min
echo RESULT powerup.order_sd = $&order_sd
wrdata @WAVE@ v(n_VBAT) v(n_VSYS) v(n_VDD_1V8) v(n_VDD_3V0) v(n_VDD_SD) v(n_VDD_MIC) v(n_VMOT)
quit
.endc
.end
* included: C4 C5 C1 C2 R1 C11 C71 C85 C88 C86 C87 C72 C73 C74 C75 C76 C77 C78 C79 C80 R71 R72 RT1 C31 C35 C32 C36 C81 C82 C60 C61 C21 C83 C84 R61 R62 BT1 U2 U11 M1
* excluded: L1(net outside this test: DCC,DECD) C6(net outside this test: DECD) FB1(net outside this test: DECA,DECD) C7(net outside this test: DECA) C14(net outside this test: DECA) C10(net outside this test: VDD_USB_3V3) R2(net outside this test: TXRTUNE) L2(net outside this test: ANT1_NODE,ANT2_NODE) C3(net outside this test: ANT2_NODE) L3(net outside this test: ANT2_NODE,ANT3_NODE) C12(net outside this test: ANT3_NODE) L4(net outside this test: ANT3_NODE,RF_FEED) C13(DNP) LT1(net outside this test: ANT_TRIM) C89(DNP) L71(net outside this test: SW1) L72(net outside this test: SW2) R57(net outside this test: PMIC_SDA) R58(net outside this test: PMIC_SCL) R31(net outside this test: MIC1_DATA,MIC_A_DATA) R32(net outside this test: MIC2_DATA,MIC_A_DATA) R60(net outside this test: SDC_MISO) R63(net outside this test: SD_DAT1) R64(net outside this test: SD_DAT2) R65(net outside this test: SDC_CS) L10(net outside this test: SGM_SW1,SGM_SW2) C22(net outside this test: SGM_AVIN) C23(net outside this test: SGM_C1N,SGM_C1P) C24(net outside this test: SGM_VOUT) C25(net outside this test: ELVDD) C26(net outside this test: SGM_AVDD) C27(net outside this test: SGM_VON) C28(net outside this test: ELVSS) C29(net outside this test: ELVSS) R66(net outside this test: OLED_PWR_EN)
