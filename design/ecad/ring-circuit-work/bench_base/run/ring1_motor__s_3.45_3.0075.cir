* ring test 1: motor start 175 mA and run 80 mA with a recording running
* generated by make_decks.py from design/ecad/ring-circuit-work/base/design/ecad/ring
.include "design/sim/circuit/models/tlv755p30.lib"
.include "design/sim/circuit/models/npm1304.lib"
.param ocv=3.45
.param rcell=3.0075
.param icl=0.56
.param rdo=0.65
CC4 n_VDD_1V8 0 1e-05 ; 10uF
CC5 n_VDD_1V8 0 1e-07 ; 100nF
CC1 n_VDD_1V8 0 1e-07 ; 100nF
CC2 n_VDD_1V8 0 1e-07 ; 100nF
RR1 n_VBUS n_U1_VBUS 2.2 ; 2.2R
CC11 n_U1_VBUS 0 4.7e-06 ; 4.7uF
CC71 n_VBUS 0 1e-06 ; 1.0uF 25V
CC85 n_VBAT 0 2.2e-06 ; 2.2uF
CC88 n_VSYS 0 1e-05 ; 10uF
CC86 n_VDD_MIC 0 1e-06 ; 1.0uF
CC87 n_VDD_SD 0 1e-06 ; 1.0uF
CC72 n_VBUS 0 1e-07 ; 100nF
CC73 n_VBUSOUT 0 1e-06 ; 1.0uF
CC74 n_VSYS 0 1e-05 ; 10uF
CC75 n_VSYS 0 1e-05 ; 10uF
CC76 n_VSYS 0 1e-09 ; 1.0nF
CC77 n_VSYS 0 1e-09 ; 1.0nF
CC78 n_VDD_1V8 0 1e-05 ; 10uF
CC79 n_VDD_3V0 0 1e-05 ; 10uF
CC80 n_VDD_1V8 0 1e-07 ; 100nF
RR71 n_VSET1 0 47000 ; 47k
RR72 n_VSET2 0 150000 ; 150k
RRT1 n_NTC 0 10000 ; 10k NTC
CC31 n_VDD_MIC 0 1e-06 ; 1uF
CC35 n_VDD_MIC 0 1e-09 ; 1nF C0G
CC32 n_VDD_MIC 0 1e-06 ; 1uF
CC36 n_VDD_MIC 0 1e-09 ; 1nF C0G
CC81 n_VDD_1V8 0 1e-07 ; 100nF
CC82 n_VDD_SD 0 1e-07 ; 100nF
CC60 n_VDD_SD 0 2.2e-06 ; 2.2uF
CC61 n_VDD_SD 0 1e-07 ; 100nF
CC21 n_VBAT 0 4.7e-06 ; 4.7uF
CC83 n_VBAT 0 1e-05 ; 10uF
CC84 n_VMOT 0 1e-05 ; 10uF
RR61 n_MOTOR n_MOT_EN 100 ; 100R
RR62 n_MOT_EN 0 100000 ; 100k
* BT1 cell: 4.35V 20-27mAh at US9 (17.6mAh min at US7) curved ; its capacity (read from parts.csv) is not used by a DC or short test; open-circuit voltage and series resistance are parameters
Vocv cell_i 0 PWL(0 0 100u {ocv})
Rcellx cell_i n_VBAT {rcell}
Vvbus n_VBUS 0 DC 0 ; no case present
Vls1 ls1en 0 PWL(0 0 10m 0 10.001m 1) ; host enables LDSW1 (microphones) at 10 ms
Vls2 ls2en 0 PWL(0 0 5m 0 5.001m 1) ; host enables LDSW2 (storage) at 5 ms
Vchg chgen 0 0
XU2 n_VBUS n_VBUSOUT n_VSYS n_VBAT n_VDD_1V8 n_VDD_3V0 n_VDD_1V8 n_VDD_MIC n_VDD_3V0 n_VDD_SD n_VSET1 n_VSET2 ls1en ls2en chgen NPM1304
XU11 n_VBAT n_VMOT n_MOT_EN 0 TLV755P30 params: icl={icl} rdo={rdo}
Vmotor n_MOTOR 0 PWL(0 0 0.03 0 0.030001 1.8 0.11 1.8 0.110001 0) ; U1 pin P3.01 MOTOR, 1.8 V logic, one 0.08 s pulse (firmware.md 3.1 M1)
* M1: 17.1429 ohm for the first 0.01 s of the pulse (Jinlong W0525AB001D spec p6 item 3-1-5: starting current below 175 mA at 3.0 V, rotor held), then 37.5 ohm (Jinlong spec p6 item 3-1-4: rated current below 80 mA at 3.0 V)
Bm n_VMOT 0 I = v(n_VMOT) / ((time < 0.04) ? 17.1429 : 37.5)
Bu1 n_VDD_1V8 0 I = (time > 0.015) ? 0.003 : 0 ; U1 architecture.md line 89: main chip 3.0 mA at 1.8 V, estimate
Bmic5 n_VDD_MIC 0 I = (time > 0.015) ? 0.00063 : 0 ; U5 firmware.md 8.5: SPK0641HT4H-1 draws 0.63 mA at 1.8 V
Bmic6 n_VDD_MIC 0 I = (time > 0.015) ? 0.00063 : 0 ; U6, same
Bsd n_VDD_SD 0 I = (time > 0.015) ? 0.025 : 0 ; U3 CS CSNP32GCR01-BOW datasheet p8 IOP write 25 mA max (motor-drive.md 2.4)
Bvci n_VDD_3V0 0 I = (time > 0.015) ? 0.0032 : 0 ; DISP1 VCI architecture.md line 101: screen VCI 3.2 mA
Biov n_VDD_1V8 0 I = (time > 0.015) ? 0.001 : 0 ; DISP1 IOVCC architecture.md line 101: screen IOVCC 1 mA
Bscr n_VBAT 0 I = (time > 0.015) ? 0.0436 / max(v(n_VBAT), 1) : 0 ; U4 panel supply on PVIN (VBAT): architecture.md line 101: screen on, full white, about 55 mW, minus the VCI and IOVCC power above
.options reltol=1e-4 abstol=1e-12 vntol=1e-7 ; tmax below sets the time resolution; results were checked for convergence (sim-notes.md)
.tran 1u 0.15 0 5u uic
.control
run
meas tran vbat_min min v(n_VBAT) from=0.0305 to=0.11
meas tran v18_min min v(n_VDD_1V8) from=0.03 to=0.11
meas tran v18_max max v(n_VDD_1V8) from=0.03 to=0.11
meas tran v30_min min v(n_VDD_3V0) from=0.03 to=0.11
meas tran v30_max max v(n_VDD_3V0) from=0.03 to=0.11
meas tran vmot_min min v(n_VMOT) from=0.0311 to=0.11
meas tran vsys_min min v(n_VSYS) from=0.03 to=0.11
meas tran vbat_settled find v(n_VBAT) at=0.0399
meas tran ibat_max max i(v.xu2.vsb) from=0.03 to=0.11
meas tran ildo_max max i(v.xu11.vs) from=0.03 to=0.11
meas tran icell_pk min i(vocv) from=0.03 to=0.11
meas tran ibuck2_max max i(v.xu2.vsn2) from=0.03 to=0.11
echo RESULT motor.vbat_min = $&vbat_min
echo RESULT motor.v18_min = $&v18_min
echo RESULT motor.v18_max = $&v18_max
echo RESULT motor.v30_min = $&v30_min
echo RESULT motor.v30_max = $&v30_max
echo RESULT motor.vmot_min = $&vmot_min
echo RESULT motor.vsys_min = $&vsys_min
echo RESULT motor.vbat_settled = $&vbat_settled
echo RESULT motor.ibat_max = $&ibat_max
echo RESULT motor.ildo_max = $&ildo_max
echo RESULT motor.icell_pk = $&icell_pk
echo RESULT motor.ibuck2_max = $&ibuck2_max
wrdata design/ecad/ring-circuit-work/bench_base/run/ring1_motor__s_3.45_3.0075.wave.txt v(n_VBAT) v(n_VSYS) v(n_VDD_1V8) v(n_VDD_3V0) v(n_VMOT) v(n_VDD_SD)
quit
.endc
.end
* included: C4 C5 C1 C2 R1 C11 C71 C85 C88 C86 C87 C72 C73 C74 C75 C76 C77 C78 C79 C80 R71 R72 RT1 C31 C35 C32 C36 C81 C82 C60 C61 C21 C83 C84 R61 R62 BT1 U2 U11 M1 U1 U5 U6 U3 U4 DISP1
* excluded: L1(net outside this test: DCC,DECD) C6(net outside this test: DECD) FB1(net outside this test: DECA,DECD) C7(net outside this test: DECA) C14(net outside this test: DECA) C10(net outside this test: VDD_USB_3V3) R2(net outside this test: TXRTUNE) L2(net outside this test: ANT1_NODE,ANT2_NODE) C3(net outside this test: ANT2_NODE) L3(net outside this test: ANT2_NODE,ANT3_NODE) C12(net outside this test: ANT3_NODE) L4(net outside this test: ANT3_NODE,RF_FEED) C13(DNP) LT1(net outside this test: ANT_TRIM) C89(DNP) L71(net outside this test: SW1) L72(net outside this test: SW2) R57(net outside this test: PMIC_SDA) R58(net outside this test: PMIC_SCL) R31(net outside this test: MIC1_DATA,MIC_A_DATA) R32(net outside this test: MIC2_DATA,MIC_A_DATA) R60(net outside this test: SDC_MISO) R63(net outside this test: SD_DAT1) R64(net outside this test: SD_DAT2) R65(net outside this test: SDC_CS) L10(net outside this test: SGM_SW1,SGM_SW2) C22(net outside this test: SGM_AVIN) C23(net outside this test: SGM_C1N,SGM_C1P) C24(net outside this test: SGM_VOUT) C25(net outside this test: ELVDD) C26(net outside this test: SGM_AVDD) C27(net outside this test: SGM_VON) C28(net outside this test: ELVSS) C29(net outside this test: ELVSS) R66(net outside this test: OLED_PWR_EN)
