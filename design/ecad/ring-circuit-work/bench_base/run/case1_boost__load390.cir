* case test 1: cell to PMID boost (BQ25895 boost mode) to VRING through the current limit part U5
* generated by make_decks.py from design/ecad/case
.include "design/sim/circuit/models/bq25895_boost.lib"
.include "design/sim/circuit/models/tps2553.lib"
.include "design/sim/circuit/models/tpd4e05u06.lib"
.param ocv=3.0
.param acc=-0.03
.param corner=0
.param load=0.39
.param rshort=1e9
CC9 n_3V3 0 1e-05 ; 10uF
CC10 n_3V3 0 1e-07 ; 100nF
RR17 n_VRING_FAULT_N n_3V3 10000 ; 10k
RR25 n_VRING_EN 0 100000 ; 100k
CC2 n_PMID 0 2.2e-05 ; 22uF
CC3 n_PMID 0 2.2e-05 ; 22uF
CC6 n_BAT 0 1e-05 ; 10uF
CC12 n_3V3 0 2.2e-05 ; 22uF
CC16 n_PMID 0 1e-07 ; 100nF
CC15 n_VRING 0 1e-05 ; 10uF
RR12 n_VRING n_VRING_SENSE 100000 ; 100k
RR13 n_VRING_SENSE 0 47000 ; 47k
CC13 n_3V3 0 1e-07 ; 100nF
CC14 n_3V3 0 4.7e-06 ; 4.7uF
* BT1 cell 700mAh 3.7V: open-circuit voltage and series resistance are parameters; internal impedance below 60 mohm (cell sheet p1)
Vocv cell_i 0 DC {ocv}
Rcellx cell_i n_BAT 0.06
* R5 (U5 ILIM resistor) = 59.0k from parts.csv: the model reads it as the parameter rk (kohm)
XU2 n_BAT n_PMID BQ25895BOOST params: acc={acc}
XU5 n_PMID n_VRING n_VRING_EN 0 TPS2553 params: rk=59 corner={corner}
XU6 n_USB_Dp n_USB_Dn n_VRING n_VRING 0 TPD4E05U06
V3v3 n_3V3 0 3.3 ; ESP32 side logic rail (3V3), the R17 pull-up and the enable come from the netlist
Ven n_VRING_EN 0 3.3 ; U1 pin IO15 drives VRING_EN high
Bload n_VRING 0 I = load ; ring side load, constant current (the ring draws a fixed current at 5 V in this test)
Rshortx n_VRING 0 {rshort} ; short circuit on VRING
.options reltol=1e-4 abstol=1e-12 vntol=1e-7
.op
.control
run
echo RESULT vring.vring = $&v(n_VRING)
echo RESULT vring.iout = $&i(v.xu5.vs)
echo RESULT vring.vsense = $&v(n_VRING_SENSE)
quit
.endc
.end
* included: C9 C10 R17 R25 C2 C3 C6 C12 C16 C15 R12 R13 C13 C14 BT1 R5 U2 U5 U6
* excluded: R23(net outside this test: EN) C30(net outside this test: EN) R22(net outside this test: BOOT) R14(net outside this test: I2C_SDA) R15(net outside this test: I2C_SCL) R16(net outside this test: CHG_INT_N) R21(net outside this test: CHG_CE_N) R8(net outside this test: LED_KR,LED_R) R9(net outside this test: LED_G,LED_KG) R10(net outside this test: LED_B,LED_KB) C1(net outside this test: VBUS_IN) C4(net outside this test: SYS) C5(net outside this test: SYS) C7(net outside this test: BTST,SW) C8(net outside this test: REGN) L1(net outside this test: SW,SYS) R11(net outside this test: ILIM) RT1(net outside this test: REGN,TS) RT2(net outside this test: TS) TH1(net outside this test: TS) R24(net outside this test: CHG_STAT) R28(net outside this test: CHG_DSEL) R27(net outside this test: CHG_OTG) L2(net outside this test: U3_L1,U3_L2) R3(net outside this test: FB) R4(net outside this test: FB) C11(net outside this test: SYS) R1(net outside this test: CC1) R2(net outside this test: CC2) R6(net outside this test: CC1,CC1_SENSE) R7(net outside this test: CC2,CC2_SENSE) R5(skipped by the test) R26(net outside this test: SD_CLK,SD_CLK_U4) R18(net outside this test: SD_CMD) R19(net outside this test: SD_D0) R20(net outside this test: SD_D1) R29(net outside this test: SD_D2) R30(net outside this test: SD_D3)
