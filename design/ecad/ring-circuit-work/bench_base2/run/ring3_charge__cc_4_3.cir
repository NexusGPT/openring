* ring test 3: charge path from the case VBUS 5 V through the pads and U9 to the power chip
* generated by make_decks.py from design/ecad/ring-circuit-work/base2/design/ecad/ring
.include "design/sim/circuit/models/tlv755p30.lib"
.include "design/sim/circuit/models/tpd4e05u06.lib"
.include "design/sim/circuit/models/npm1304.lib"
.param ocv=4.0
.param rcell=3.0
.param rpath=0.5
.param ibuslim=1.5
.param loads=0
CC4 n_VDD_1V8 0 1e-05 ; 10uF
CC5 n_VDD_1V8 0 1e-07 ; 100nF
CC1 n_VDD_1V8 0 1e-07 ; 100nF
CC2 n_VDD_1V8 0 1e-07 ; 100nF
RR1 n_VBUS n_U1_VBUS 2.2 ; 2.2R
CC11 n_U1_VBUS 0 4.7e-06 ; 4.7uF
CC71 n_VBUS 0 1e-06 ; 1.0uF 25V
CC85 n_VBAT 0 2.2e-06 ; 2.2uF
CC88 n_VSYS 0 1e-05 ; 10uF
CC86 n_VDD_MIC 0 1e-06 ; 1.0uF
CC87 n_VDD_SD 0 1e-06 ; 1.0uF
CC72 n_VBUS 0 1e-07 ; 100nF
CC73 n_VBUSOUT 0 1e-06 ; 1.0uF
CC74 n_VSYS 0 1e-05 ; 10uF
CC75 n_VSYS 0 1e-05 ; 10uF
CC76 n_VSYS 0 1e-09 ; 1.0nF
CC77 n_VSYS 0 1e-09 ; 1.0nF
CC78 n_VDD_1V8 0 1e-05 ; 10uF
CC79 n_VDD_3V0 0 1e-05 ; 10uF
CC80 n_VDD_1V8 0 1e-07 ; 100nF
RR71 n_VSET1 0 47000 ; 47k
RR72 n_VSET2 0 150000 ; 150k
RRT1 n_NTC 0 10000 ; 10k NTC
CC31 n_VDD_MIC 0 1e-06 ; 1uF
CC35 n_VDD_MIC 0 1e-09 ; 1nF C0G
CC32 n_VDD_MIC 0 1e-06 ; 1uF
CC36 n_VDD_MIC 0 1e-09 ; 1nF C0G
CC81 n_VDD_1V8 0 1e-07 ; 100nF
CC82 n_VDD_SD 0 1e-07 ; 100nF
CC60 n_VDD_SD 0 2.2e-06 ; 2.2uF
CC61 n_VDD_SD 0 1e-07 ; 100nF
CC21 n_VBAT 0 4.7e-06 ; 4.7uF
CC83 n_VBAT 0 1e-05 ; 10uF
CC84 n_VMOT 0 1e-05 ; 10uF
RR61 n_MOTOR n_MOT_EN 100 ; 100R
RR62 n_MOT_EN 0 100000 ; 100k
* BT1 cell: 4.35V 20-27mAh at US9 (17.6mAh min at US7) curved ; its capacity (read from parts.csv) is not used by a DC or short test; open-circuit voltage and series resistance are parameters
Vocv cell_i 0 PWL(0 0 100u {ocv})
Rcellx cell_i n_VBAT {rcell}
* case side: VBUS 5 V (case TPS2553 output, 5 V), path resistance spring pin + wire + pad + flex = rpath (no file gives it, swept 0 to 2 ohm)
Vcase vcase 0 PWL(0 0 10m 0 11m 5)
Rpathx vcase n_VBUS {rpath}
Vls1 ls1en 0 {loads} ; the load switches are on when the recording loads are on
Vls2 ls2en 0 {loads}
Vchg chgen 0 PWL(0 0 5m 0 5.001m 1) ; charger enabled by the host before VBUS arrives
XU2 n_VBUS n_VBUSOUT n_VSYS n_VBAT n_VDD_1V8 n_VDD_3V0 n_VDD_1V8 n_VDD_MIC n_VDD_3V0 n_VDD_SD n_VSET1 n_VSET2 ls1en ls2en chgen NPM1304 params: ibuslim={ibuslim}
XU9 n_USB_DP n_USB_DN n_VBUS n_VBUS 0 TPD4E05U06
XU11 n_VBAT n_VMOT n_MOT_EN 0 TLV755P30
Vmotor n_MOTOR 0 0
* loads: a recording while charging (worst demand on VBUS); loads scale with the parameter 'loads' (0 or 1)
Bl18 n_VDD_1V8 0 I = loads * (0.003 + 0.001)
Bl30 n_VDD_3V0 0 I = loads * 0.0032
Blmic n_VDD_MIC 0 I = loads * 0.00126
Blsd n_VDD_SD 0 I = loads * 0.025
Blscr n_VBAT 0 I = loads * 0.0436 / max(v(n_VBAT), 1)
.options method=gear itl4=100 reltol=0.005 abstol=1e-10 vntol=1e-5 ; needed when VBUS becomes valid in the middle of the ramp (the default options abort)
.tran 20u 0.12 0 50u uic
.control
run
meas tran icc avg i(vocv) from=0.08 to=0.12
meas tran vbat_t avg v(n_VBAT) from=0.08 to=0.12
meas tran ibus avg i(v.xu2.vsv) from=0.08 to=0.12
meas tran ibus_pk max i(v.xu2.vsv) from=0.03 to=0.12
meas tran vbus_chip avg v(n_VBUS) from=0.08 to=0.12
meas tran vsys avg v(n_VSYS) from=0.08 to=0.12
echo RESULT charge.icc = $&icc
echo RESULT charge.vbat_t = $&vbat_t
echo RESULT charge.ibus = $&ibus
echo RESULT charge.ibus_pk = $&ibus_pk
echo RESULT charge.vbus_chip = $&vbus_chip
echo RESULT charge.vsys = $&vsys
wrdata design/ecad/ring-circuit-work/bench_base2/run/ring3_charge__cc_4_3.wave.txt v(n_VBAT) v(n_VSYS) v(n_VBUS) v(vcase)
quit
.endc
.end
* included: C4 C5 C1 C2 R1 C11 C71 C85 C88 C86 C87 C72 C73 C74 C75 C76 C77 C78 C79 C80 R71 R72 RT1 C31 C35 C32 C36 C81 C82 C60 C61 C21 C83 C84 R61 R62 BT1 U2 U9 U11
* excluded: L1(net outside this test: DCC,DECD) C6(net outside this test: DECD) FB1(net outside this test: DECA,DECD) C7(net outside this test: DECA) C14(net outside this test: DECA) C10(net outside this test: VDD_USB_3V3) R2(net outside this test: TXRTUNE) L2(net outside this test: ANT1_NODE,ANT2_NODE) C3(net outside this test: ANT2_NODE) L3(net outside this test: ANT2_NODE,ANT3_NODE) C12(net outside this test: ANT3_NODE) L4(net outside this test: ANT3_NODE,RF_FEED) C13(DNP) LT1(net outside this test: ANT_TRIM) C89(DNP) L71(net outside this test: SW1) L72(net outside this test: SW2) R57(net outside this test: PMIC_SDA) R58(net outside this test: PMIC_SCL) R31(net outside this test: MIC1_DATA,MIC_A_DATA) R32(net outside this test: MIC2_DATA,MIC_A_DATA) R60(net outside this test: SDC_MISO) R63(net outside this test: SD_DAT1) R64(net outside this test: SD_DAT2) R65(net outside this test: SDC_CS) L10(net outside this test: SGM_SW1,SGM_SW2) C22(net outside this test: SGM_AVIN) C23(net outside this test: SGM_C1N,SGM_C1P) C24(net outside this test: SGM_VOUT) C25(net outside this test: ELVDD) C26(net outside this test: SGM_AVDD) C27(net outside this test: SGM_VON) C28(net outside this test: ELVSS) C29(net outside this test: ELVSS) R66(net outside this test: OLED_PWR_EN)
