* case test 4: RGB LED currents from 3V3 through R8, R9, R10 with the ESP32 pins low
* generated by make_decks.py from design/ecad/case
CC9 n_3V3 0 1e-05 ; 10uF
CC10 n_3V3 0 1e-07 ; 100nF
RR8 n_LED_R n_LED_KR 510 ; 510R
RR9 n_LED_G n_LED_KG 270 ; 270R
RR10 n_LED_B n_LED_KB 270 ; 270R
CC12 n_3V3 0 2.2e-05 ; 22uF
CC13 n_3V3 0 1e-07 ; 100nF
CC14 n_3V3 0 4.7e-06 ; 4.7uF
.param n=4.0
.param v33=3.308 ; 3V3 rail = 0.5 V x (1 + R3 / R4) with R3 and R4 from parts.csv, see test 5
V3v3 n_SYS 0 {v33}
Vlow_R n_LED_R 0 0 ; U1 pin driven low (best case 0 V)
.model dled_R D(IS={0.02/exp(2/(n*0.02585))} N={n} RS=0)
Dled_R n_SYS n_LED_KR dled_R ; R die, typical Vf 2 V at 20 mA
Vlow_G n_LED_G 0 0 ; U1 pin driven low (best case 0 V)
.model dled_G D(IS={0.02/exp(3.3/(n*0.02585))} N={n} RS=0)
Dled_G n_SYS n_LED_KG dled_G ; G die, typical Vf 3.3 V at 20 mA
Vlow_B n_LED_B 0 0 ; U1 pin driven low (best case 0 V)
.model dled_B D(IS={0.02/exp(3.3/(n*0.02585))} N={n} RS=0)
Dled_B n_SYS n_LED_KB dled_B ; B die, typical Vf 3.3 V at 20 mA
.options reltol=1e-4 abstol=1e-12 vntol=1e-7
.op
.control
run
let i_R = i(vlow_R)
let i_G = i(vlow_G)
let i_B = i(vlow_B)
echo RESULT led.red = $&i_R
echo RESULT led.green = $&i_G
echo RESULT led.blue = $&i_B
quit
.endc
.end
* included: C9 C10 R8 R9 R10 C12 C13 C14 LED1
* excluded: R23(net outside this test: EN) C30(net outside this test: EN) R22(net outside this test: BOOT) R14(net outside this test: I2C_SDA) R15(net outside this test: I2C_SCL) R16(net outside this test: CHG_INT_N) R17(net outside this test: VRING_FAULT_N) R21(net outside this test: CHG_CE_N) R25(net outside this test: VRING_EN) C1(net outside this test: VBUS_IN) C2(net outside this test: PMID) C3(net outside this test: PMID) C4(net outside this test: SYS) C5(net outside this test: SYS) C6(net outside this test: BAT) C7(net outside this test: BTST,SW) C8(net outside this test: REGN) L1(net outside this test: SW,SYS) R11(net outside this test: ILIM) RT1(net outside this test: REGN,TS) RT2(net outside this test: TS) TH1(net outside this test: TS) R24(net outside this test: CHG_STAT) R28(net outside this test: CHG_DSEL) R27(net outside this test: CHG_OTG) L2(net outside this test: U3_L1,U3_L2) R3(net outside this test: FB) R4(net outside this test: FB) C11(net outside this test: SYS) R1(net outside this test: CC1) R2(net outside this test: CC2) R6(net outside this test: CC1,CC1_SENSE) R7(net outside this test: CC2,CC2_SENSE) R5(net outside this test: U5_ILIM) C16(net outside this test: PMID) C15(net outside this test: VRING) R12(net outside this test: VRING,VRING_SENSE) R13(net outside this test: VRING_SENSE) R26(net outside this test: SD_CLK,SD_CLK_U4) R18(net outside this test: SD_CMD) R19(net outside this test: SD_D0) R20(net outside this test: SD_D1) R29(net outside this test: SD_D2) R30(net outside this test: SD_D3)
