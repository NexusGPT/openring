* case test 4: RGB LED currents from SYS through R8, R9, R10 with the ESP32 pins low (lit) or high (off)
* generated by make_decks.py from design/ecad/case
RR8 n_LED_R n_LED_KR 510 ; 510R
RR9 n_LED_G n_LED_KG 270 ; 270R
RR10 n_LED_B n_LED_KB 270 ; 270R
.param vsys=3.5 ; SYS, set by the test: 3.5 V minimum system voltage (BQ25895 p35) to 4.35 V (lead's range)
.param v33=3.30769 ; 3V3 rail = 0.5 V x (1 + R3 / R4) with R3 = 511k and R4 = 91k from parts.csv
.param vshift=0 ; shift of the LED curves in volt (plus 0.15 V weakest die, minus 0.15 V strongest die; the reading error of the graphs)
.param vdrv=0 ; level the U1 pins drive: 0 V lit, v33 off (the software drives them high at start-up)
.param rpin=17.6786 ; pin low-side resistance: VOL 0.495 V at IOL 28 mA (ESP32-S3-MINI-1 p27)
Vsysx n_SYS 0 {vsys}
V3v3 n_3V3 0 {v33}
Vdrv_R drvR 0 {vdrv}
Rpin_R drvR n_LED_R {rpin} ; U1 pin of R8
Bled_R n_SYS n_LED_KR I = pwl(v(n_SYS) - v(n_LED_KR) - {vshift}, 0, 0, 1.7, 0, 1.85, 0.002, 1.93, 0.005, 2, 0.02, 2.06, 0.03) ; R die: curve of the sheet p3
Vdrv_G drvG 0 {vdrv}
Rpin_G drvG n_LED_G {rpin} ; U1 pin of R9
Bled_G n_SYS n_LED_KG I = pwl(v(n_SYS) - v(n_LED_KG) - {vshift}, 0, 0, 2.5, 0, 2.75, 0.002, 3, 0.005, 3.3, 0.02, 3.45, 0.025) ; G die: curve of the sheet p3
Vdrv_B drvB 0 {vdrv}
Rpin_B drvB n_LED_B {rpin} ; U1 pin of R10
Bled_B n_SYS n_LED_KB I = pwl(v(n_SYS) - v(n_LED_KB) - {vshift}, 0, 0, 2.4, 0, 2.7, 0.002, 2.85, 0.005, 3.3, 0.02, 3.5, 0.03) ; B die: curve of the sheet p3
.options reltol=1e-4 abstol=1e-12 vntol=1e-7
.op
.control
run
let i_R = abs(i(vdrv_R))
let i_G = abs(i(vdrv_G))
let i_B = abs(i(vdrv_B))
echo RESULT led.red = $&i_R
echo RESULT led.green = $&i_G
echo RESULT led.blue = $&i_B
quit
.endc
.end
* included: R8 R9 R10 LED1
* excluded: C9(net outside this test: 3V3) C10(net outside this test: 3V3) R23(net outside this test: 3V3,EN) C30(net outside this test: EN) R22(net outside this test: 3V3,BOOT) R14(net outside this test: 3V3,I2C_SDA) R15(net outside this test: 3V3,I2C_SCL) R16(net outside this test: 3V3,CHG_INT_N) R17(net outside this test: 3V3,VRING_FAULT_N) R21(net outside this test: 3V3,CHG_CE_N) R25(net outside this test: VRING_EN) C1(net outside this test: VBUS_IN) C2(net outside this test: PMID) C3(net outside this test: PMID) C4(net outside this test: SYS) C5(net outside this test: SYS) C6(net outside this test: BAT) C7(net outside this test: BTST,SW) C8(net outside this test: REGN) L1(net outside this test: SW,SYS) R11(net outside this test: ILIM) RT1(net outside this test: REGN,TS) RT2(net outside this test: TS) TH1(net outside this test: TS) R24(net outside this test: 3V3,CHG_STAT) R28(net outside this test: 3V3,CHG_DSEL) R27(net outside this test: CHG_OTG) L2(net outside this test: U3_L1,U3_L2) R3(net outside this test: 3V3,FB) R4(net outside this test: FB) C11(net outside this test: SYS) C12(net outside this test: 3V3) R1(net outside this test: CC1) R2(net outside this test: CC2) R6(net outside this test: CC1,CC1_SENSE) R7(net outside this test: CC2,CC2_SENSE) R5(net outside this test: U5_ILIM) C16(net outside this test: PMID) C15(net outside this test: VRING) R12(net outside this test: VRING,VRING_SENSE) R13(net outside this test: VRING_SENSE) R26(net outside this test: SD_CLK,SD_CLK_U4) R18(net outside this test: 3V3,SD_CMD) R19(net outside this test: 3V3,SD_D0) R20(net outside this test: 3V3,SD_D1) R29(net outside this test: 3V3,SD_D2) R30(net outside this test: 3V3,SD_D3) C13(net outside this test: 3V3) C14(net outside this test: 3V3)
