* case test 2: BQ25895 enable line CE (pulled up by R21 to 3V3) against the charger's input thresholds, and the charge current with the register defaults when CE is low
* generated by make_decks.py from design/ecad/case
CC9 n_3V3 0 1e-05 ; 10uF
CC10 n_3V3 0 1e-07 ; 100nF
RR21 n_CHG_CE_N n_3V3 10000 ; 10k
CC12 n_3V3 0 2.2e-05 ; 22uF
CC13 n_3V3 0 1e-07 ; 100nF
CC14 n_3V3 0 4.7e-06 ; 4.7uF
* power-on level of CE: R21 (netlist, parts.csv) from CE to the 3V3 rail; 3V3 source from the test (3.0 V lowest allowed by the module, p27)
.param v33=3.3
V33x n_3V3 0 {v33}
* CE input leakage 1 uA (BQ25895 p10 IIN_BIAS) plus the module pin's input current 50 nA (ESP32-S3-MINI-1 p27 IIH), both worst case pulling CE down
.param ileak=1.05e-6
Ileakx n_CHG_CE_N 0 DC {ileak}
* module pin IO18 before the software drives it: high impedance with the internal weak pull-down 45 kohm (p27 RPD, worst case)
.param rpd=45e3
Rpdx n_CHG_CE_N 0 {rpd}
* module pin driven low by the software: a source at VOL (0.1 x VDD, p27) through rdrv; rdrv = 1e12 means not driven
.param rdrv=1.0
.param vpin=0.0
Rdrvx n_CHG_CE_N pinsrc {rdrv}
Vpinx pinsrc 0 {vpin}
.param vih=1.3 ; BQ25895 p10 input high threshold of CE
* defaults of the BQ25895 registers, each with its page in pass-lines.md section B: ICHG 2.048 A (p36), VREG 4.208 V (p38), IINLIM 0.5 A (p32), KILIM 320 / 355 / 390 (p9)
.param ichg_reg=2.048
.param vreg=4.208
.param iinlim=0.5
.param rilim=260 ; R11 from parts.csv
.param eta=0.90 ; MODEL CHOICE, converter efficiency
.param psys=0.9 ; no other load, the largest charge current
* case cell at 3.7 V nominal with 60 mohm; VBUS 5 V from a USB source; input limit = min(register, ILIM pin KILIM/RILIM)
Vbus vbus 0 5
Vocv cell_i 0 3.7
Rcellx cell_i nbat 0.06
.param ilim_pin_min = {320/rilim}
.param iin = {min(iinlim, ilim_pin_min)}
* charge current from the input power: (eta * 5 V * iin - psys) / Vbat, clamped by the register ICHG and by the CV limit; charging only while V(CE) is below VIH (p4 and p21: charging is enabled when CE is low; between VIL and VIH the level is undefined and counts as charging, the worst case)
Bchg2 0 nbat I = (v(n_CHG_CE_N) < {vih}) * min(ichg_reg, min(max((eta*5*iin - psys)/max(v(nbat),2.5), 0), max((vreg - v(nbat))*1000, 0)))
Vn_ichg n_ichg 0 {ichg_reg}
Vn_vreg n_vreg 0 {vreg}
Vn_pin n_pin 0 {ilim_pin_min}
.options reltol=1e-4 abstol=1e-12 vntol=1e-7
.op
.control
run
let ichg_in = i(vocv)
echo RESULT charge.ce_v = $&v(n_CHG_CE_N)
echo RESULT charge.ichg_reg_default = $&v(n_ichg)
echo RESULT charge.vreg_default = $&v(n_vreg)
echo RESULT charge.ilim_pin_min = $&v(n_pin)
echo RESULT charge.icc = $&ichg_in
quit
.endc
.end
* included: C9 C10 R21 C12 C13 C14 R11
* excluded: R23(net outside this test: EN) C30(net outside this test: EN) R22(net outside this test: BOOT) R14(net outside this test: I2C_SDA) R15(net outside this test: I2C_SCL) R16(net outside this test: CHG_INT_N) R17(net outside this test: VRING_FAULT_N) R25(net outside this test: VRING_EN) R8(net outside this test: LED_KR,LED_R) R9(net outside this test: LED_G,LED_KG) R10(net outside this test: LED_B,LED_KB) C1(net outside this test: VBUS_IN) C2(net outside this test: PMID) C3(net outside this test: PMID) C4(net outside this test: SYS) C5(net outside this test: SYS) C6(net outside this test: BAT) C7(net outside this test: BTST,SW) C8(net outside this test: REGN) L1(net outside this test: SW,SYS) R11(net outside this test: ILIM) RT1(net outside this test: REGN,TS) RT2(net outside this test: TS) TH1(net outside this test: TS) R24(net outside this test: CHG_STAT) R28(net outside this test: CHG_DSEL) R27(net outside this test: CHG_OTG) L2(net outside this test: U3_L1,U3_L2) R3(net outside this test: FB) R4(net outside this test: FB) C11(net outside this test: SYS) R1(net outside this test: CC1) R2(net outside this test: CC2) R6(net outside this test: CC1,CC1_SENSE) R7(net outside this test: CC2,CC2_SENSE) R5(net outside this test: U5_ILIM) C16(net outside this test: PMID) C15(net outside this test: VRING) R12(net outside this test: VRING,VRING_SENSE) R13(net outside this test: VRING_SENSE) R26(net outside this test: SD_CLK,SD_CLK_U4) R18(net outside this test: SD_CMD) R19(net outside this test: SD_D0) R20(net outside this test: SD_D1) R29(net outside this test: SD_D2) R30(net outside this test: SD_D3)
