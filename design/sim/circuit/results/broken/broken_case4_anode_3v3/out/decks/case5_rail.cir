* case test 5: 3V3 rail set by the feedback divider R3, R4 of U3 (TPS63802)
* generated by make_decks.py from design/sim/circuit/results/broken/broken_case4_anode_3v3/case
.param vfb=0.5
CC9 n_3V3 0 1e-05 ; 10uF
CC10 n_3V3 0 1e-07 ; 100nF
RR3 n_3V3 n_FB 511000 ; 511k
RR4 n_FB 0 91000 ; 91k
CC12 n_3V3 0 2.2e-05 ; 22uF
CC13 n_3V3 0 1e-07 ; 100nF
CC14 n_3V3 0 4.7e-06 ; 4.7uF
* U3 as an error amplifier around the feedback pin: VOUT = clamp(1e5 x (VFB - V(FB))), VFB 500 mV (p6); loop closed by R3, R4 of the netlist
Bu3 n_3V3 0 V = max(0, min(5.2, 1e5*({vfb} - v(n_FB))))
.options reltol=1e-4 abstol=1e-12 vntol=1e-7
.op
.control
run
echo RESULT boost3v3.vout = $&v(n_3V3)
quit
.endc
.end
* included: C9 C10 R3 R4 C12 C13 C14 U3
* excluded: R23(net outside this test: EN) C30(net outside this test: EN) R22(net outside this test: BOOT) R14(net outside this test: I2C_SDA) R15(net outside this test: I2C_SCL) R16(net outside this test: CHG_INT_N) R17(net outside this test: VRING_FAULT_N) R21(net outside this test: CHG_CE_N) R25(net outside this test: VRING_EN) R8(net outside this test: LED_KR,LED_R) R9(net outside this test: LED_G,LED_KG) R10(net outside this test: LED_B,LED_KB) C1(net outside this test: VBUS_IN) C2(net outside this test: PMID) C3(net outside this test: PMID) C4(net outside this test: SYS) C5(net outside this test: SYS) C6(net outside this test: BAT) C7(net outside this test: BTST,SW) C8(net outside this test: REGN) L1(net outside this test: SW,SYS) R11(net outside this test: ILIM) RT1(net outside this test: REGN,TS) RT2(net outside this test: TS) TH1(net outside this test: TS) R24(net outside this test: CHG_STAT) R28(net outside this test: CHG_DSEL) R27(net outside this test: CHG_OTG) L2(net outside this test: U3_L1,U3_L2) C11(net outside this test: SYS) R1(net outside this test: CC1) R2(net outside this test: CC2) R6(net outside this test: CC1,CC1_SENSE) R7(net outside this test: CC2,CC2_SENSE) R5(net outside this test: U5_ILIM) C16(net outside this test: PMID) C15(net outside this test: VRING) R12(net outside this test: VRING,VRING_SENSE) R13(net outside this test: VRING_SENSE) R26(net outside this test: SD_CLK,SD_CLK_U4) R18(net outside this test: SD_CMD) R19(net outside this test: SD_D0) R20(net outside this test: SD_D1) R29(net outside this test: SD_D2) R30(net outside this test: SD_D3)
